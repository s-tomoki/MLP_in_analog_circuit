* Fan-in summing amplifier, N=2, mode=mc_res
* preset note: Microchip MCP6232-E/P. Ib is an ESTIMATE (pA order); Rail is an estimate (light-load headroom).
.include UniversalOpAmp2.lib

.subckt MyOpAmp 1 2 3 4 5
* pins: 1=IN+ 2=IN- 3=VCC 4=VEE 5=OUT
X_internal 1 2 3 4 5 level2 params: Avol=316228 GBW=300000 Slew=150000 Vos=0.005 Ib=1e-12 Ios=1e-12 rail=0.15 ilimit=0.023
.ends MyOpAmp

.param Rin_nom=10000 Rf_nom=10000
V+ vcc 0 2.5
V- vee 0 -2.5
Vinp inp 0 0
XU1 inp inn vcc vee out MyOpAmp
Rf inn out {mc(Rf_nom,0.05)}
Vin1 n1 0 PWL(0 -1 0.001 -1 0.001001 1 0.002 1 0.002001 -1 0.003 -1 0.003001 1 0.006 1)
Rin1 n1 inn {mc(Rin_nom,0.05)}
Vin2 n2 0 PWL(0 -1 0.002 -1 0.002001 1 0.003 1 0.003001 -1 0.004 -1 0.004001 1 0.006 1)
Rin2 n2 inn {mc(Rin_nom,0.05)}
.tran 0 0.006 0 2e-07
.step param run 1 100 1
.meas TRAN vph_lo AVG V(out) FROM=8.86478898e-05 TO=0.00091135211
.meas TRAN vph_oh1 AVG V(out) FROM=0.00108864789 TO=0.00191135211
.meas TRAN vph_oh2 AVG V(out) FROM=0.00208864789 TO=0.00291135211
.meas TRAN vph_cum1 AVG V(out) FROM=0.00308864789 TO=0.00391135211
.meas TRAN vph_cum2 AVG V(out) FROM=0.00408864789 TO=0.00491135211
.meas TRAN vph_hi AVG V(out) FROM=0.00508864789 TO=0.00591135211
.backanno
.end
